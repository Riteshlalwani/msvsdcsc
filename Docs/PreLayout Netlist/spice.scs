// Design: Ritesh/csc_full
simulator lang=spectre
global 0
include "/mnt/cadence_tools/gpdk045_v_6_0/gpdk045/../models/spectre/gpdk045.scs" section=mc

// Ritesh/camp/schematic
subckt camp EN GND INN INP Vdd Vout
ends camp

// Ritesh/OR_Gate/schematic
subckt OR_Gate A B GND Vdd Vout
ends OR_Gate

// Ritesh/AND_Gate/schematic
subckt AND_Gate A B GND Vdd Vout
ends AND_Gate

// Ritesh/Priority_encoder/schematic
subckt Priority_encoder D1 D2 D3 D4 D5 D6 D7 GND Q0 Q1 Q2 Vdd
    I31 (D4 D5 GND Vdd net23) OR_Gate
    I30 (D6 D7 GND Vdd net24) OR_Gate
    I29 (net23 net24 GND Vdd Q2) OR_Gate
    I24 (D2 D3 GND Vdd net12) OR_Gate
    I23 (net15 D6 GND Vdd net17) OR_Gate
    I22 (net17 D7 GND Vdd Q1) OR_Gate
    I2 (net10 net9 GND Vdd net6) OR_Gate
    I1 (net6 D5 GND Vdd net5) OR_Gate
    I0 (net1 D7 GND Vdd Q0) OR_Gate
    I26 (net3 net7 GND Vdd net13) AND_Gate
    I25 (net12 net13 GND Vdd net15) AND_Gate
    I7 (net19 net18 GND Vdd net16) AND_Gate
    I6 (net16 D1 GND Vdd net9) AND_Gate
    I4 (net5 net14 GND Vdd net1) AND_Gate
    I5 (D3 net11 GND Vdd net10) AND_Gate
ends Priority_encoder

// Ritesh/tristate_inv/schematic
subckt tristate_inv GND Vdd Vin Vout clk clkbar
ends tristate_inv

// Ritesh/ms_dff/schematic
subckt ms_dff D GND Q Qbar Vdd clk clkbar
    I13 (GND Vdd net7 net1 clkbar clk) tristate_inv
    I12 (GND Vdd net6 net12 clk clkbar) tristate_inv
ends ms_dff

// Ritesh/PIPO/schematic
subckt PIPO D0 D1 D2 GND Q0 Q1 Q2 Vdd clk clkbar
    I2 (D2 GND Q2 net3 Vdd clk clkbar) ms_dff
    I1 (D1 GND Q1 net2 Vdd clk clkbar) ms_dff
    I0 (D0 GND Q0 net1 Vdd clk clkbar) ms_dff
ends PIPO

// Ritesh/csc_full/schematic
I12 (EN GND Vref Vin Vdd net10) camp
I14 (EN GND net1 Vin Vdd net15) camp
I15 (EN GND net2 Vin Vdd net11) camp
I16 (EN GND net3 Vin Vdd net16) camp
I17 (EN GND net4 Vin Vdd net17) camp
I18 (EN GND net5 Vin Vdd net8) camp
I19 (EN GND net6 Vin Vdd net9) camp
I0 (net9 net8 net17 net16 net11 net15 net10 GND net12 net14 net13 Vdd) Priority_encoder
I1 (net12 net14 net13 GND Q0 Q1 Q2 Vdd clk net7) PIPO
simulatorOptions options temp=27
